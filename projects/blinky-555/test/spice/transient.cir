* blinky-555 - generated by tools/boardgen/make_spice.py from gen/netlist.py
D2 VIN VCC D_GENERIC
C3 VCC 0 100n
XU1 0 TRIG OUT VCC CONT TRIG DISCH VCC NE555
R1 VCC DISCH 10k
R2 DISCH TRIG 47k
C1 TRIG 0 10u
C2 CONT 0 10n
R3 OUT LED_A 470
D1 LED_A 0 LED_GENERIC
V_VIN VIN 0 9.0
.lib NE555.sub
.model D_GENERIC D(Is=2.5n N=1.75 Rs=0.5 BV=100 IBV=100n Cjo=4p)
.model LED_GENERIC D(Is=1e-22 N=1.6 Rs=2 BV=5 IBV=10u Cjo=10p)
.tran 0 4 0 0.0002 startup
.options plotwinsize=0
.end
